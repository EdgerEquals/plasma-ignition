* Plasma Ignition Rev B  blocks=stage2  model=ttu
.options method=gear reltol=1e-4 abstol=1e-9 vntol=1e-4 itl4=200 maxord=2
C0b bk 0 3.92615e-08 IC=5626.03
C_plug P 0 1.5e-11 IC=5626.03
* SRiso model=ttu N=6 Ae=0.0010626721829676195 le=0.22 VS=0.012752066195611434 (dB=2.000 T)
L_iso_air bk iso_m 3.48802e-07
C_iso_w bk cw_s 1.5e-12
V_iso_cw cw_s P 0
G_iso_lam 0 lam_iso iso_m P 1
C_iso_lam lam_iso 0 1
R_iso_lam lam_iso 0 1e15
* TTU scaled: k2=10.87 R=1.188e+04 C=1.347e-11
R_iso_rc iso_m iso_rc 11882.6
C_iso_rc iso_rc P 1.34651e-11
B_iso_abs iso_abs 0 V = abs((v(iso_m,P)/0.00637603))/1e6
D_iso_l iso_abs iso_lat DIDEAL
C_iso_l iso_lat 0 1u
R_iso_l iso_lat 0 10k
.model DIDEAL D(Is=1e-14 N=0.01)
B_iso_core iso_m P I = 0.0366667*(v(lam_iso)+0.0015)/0.00637603/((1/(v(iso_lat)/0.21+1))*(1/(5e-05*exp(min(10.8689*((v(lam_iso)+0.0015)/0.00637603-1)*((v(lam_iso)+0.0015)/0.00637603-1),60))+8)))

V_chg chg 0 PWL(0.000000e+00 0 1.000000e-09 0 2.000000e-09 1)
B_ch P 0 I = v(P)*(v(chg)/1 + 1/1e+09)

.control
set wr_singlescale
set wr_vecnames
option numdgt=9
tran 0.05n 1.400000e-05 0 2.500e-10 uic
wrdata /workspace/plasma-ignition/sim/out/revc_st2_ttu_a2.dat v(P) v(bk) v(lam_iso) i(L_iso_air) i(V_iso_cw) v(chg) v(iso_m)
quit
.endc
.end
