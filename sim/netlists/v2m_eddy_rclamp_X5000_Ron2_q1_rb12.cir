* PRS Rev B  blocks=full  model=eddy
.options method=gear reltol=1e-4 abstol=1e-9 vntol=1e-4 itl4=200 maxord=2
C0a a0 0 9.6e-08 IC=1100
D_igbt a0 a1 DSW
.model DSW D(Is=1e-12 N=1 Rs=1m)
L_leak a1 a2 2.10976e-06
L_pri a2 0 0.001
L_sec 0 n1 0.961 IC=0
K_x L_pri L_sec 1
C1 n1 0 1e-10 IC=0
C2 n2 0 1e-10 IC=0
C3 n3 0 1e-10 IC=0
R_bleed n3 0 1e+07
* saturable inductor SR1: Ls=8.1e-05 Lu=0.081 VS=0.017
G_SR1 0 lam_SR1 n2 n1 1
C_SR1 lam_SR1 0 1
R_SR1 lam_SR1 0 1e15
B_SR1 n2 n1 I = v(lam_SR1)/0.081 + 12333.3*((uramp((v(lam_SR1)-0.017)) + 3.4000000000000007e-05*ln(1+exp(-abs((v(lam_SR1)-0.017))/3.4000000000000007e-05))) - (uramp((-v(lam_SR1)-0.00034)) + 3.4000000000000007e-05*ln(1+exp(-abs((-v(lam_SR1)-0.00034))/3.4000000000000007e-05))) + 1.54356e-09)

* saturable inductor SR2: Ls=3.2e-06 Lu=0.0032 VS=0.0034
G_SR2 0 lam_SR2 n3 n2 1
C_SR2 lam_SR2 0 1
R_SR2 lam_SR2 0 1e15
B_SR2 n3 n2 I = v(lam_SR2)/0.0032 + 312188*((uramp((v(lam_SR2)-0.0034)) + 6.8e-06*ln(1+exp(-abs((v(lam_SR2)-0.0034))/6.8e-06))) - (uramp((-v(lam_SR2)-6.8e-05)) + 6.8e-06*ln(1+exp(-abs((-v(lam_SR2)-6.8e-05))/6.8e-06))) + 3.08713e-10)

* saturable inductor SR3: Ls=1e-08 Lu=0.001 VS=0.00068
G_SR3 0 lam_SR3 x n3 1
C_SR3 lam_SR3 0 1
R_SR3 lam_SR3 0 1e15
B_SR3 x n3 I = v(lam_SR3)/0.001 + 9.9999e+07*((uramp((v(lam_SR3)-0.00068)) + 1.3600000000000001e-06*ln(1+exp(-abs((v(lam_SR3)-0.00068))/1.3600000000000001e-06))) - (uramp((-v(lam_SR3)-1.36e-05)) + 1.3600000000000001e-06*ln(1+exp(-abs((-v(lam_SR3)-1.36e-05))/1.3600000000000001e-06))) + 6.17425e-11)

C_block x P 1e-09 IC=-4000
C0b bk 0 6.25e-08 IC=4000
C_plug P 0 1.5e-11 IC=4000
* SRiso model=eddy N=6 Ae=0.0008 le=0.22 VS=0.0095 (dB=1.979 T)
L_iso_air bk iso_m 2.7e-07
C_iso_w bk cw_s 1.5e-12
V_iso_cw cw_s P 0
G_iso_lam 0 lam_iso iso_m P 1
C_iso_lam lam_iso 0 1
R_iso_lam lam_iso 0 1e15
B_iso_core iso_m P I = 0.0366667*(2.5*tanh((v(iso_m,P)/0.0048)/0.01e6) + 4.5e-05*(v(iso_m,P)/0.0048)) + (1/2e-09)*((uramp(((v(lam_iso)+0)-0.0095)) + 1.9e-05*ln(1+exp(-abs(((v(lam_iso)+0)-0.0095))/1.9e-05))) - (uramp((-(v(lam_iso)+0)-0.00019)) + 1.9e-05*ln(1+exp(-abs((-(v(lam_iso)+0)-0.00019))/1.9e-05))) + 8.62579e-10)

V_chg chg 0 PWL(0.000000e+00 0 1.244258e-06 0 1.245258e-06 1 2.244258e-06 1 2.245258e-06 0)
B_ch P 0 I = v(P)*(v(chg)/1 + 1/1e+09)

V_mit P rc1 0
D_rc rc1 rcv DRC
.model DRC D(Is=1e-12 N=6 Rs=2 BV=1e6)
V_rc rcv 0 5000
C_rcd P 0 2p IC=4000

.control
set wr_singlescale
set wr_vecnames
option numdgt=9
tran 0.05n 1.424426e-05 0 1.000e-10 uic
wrdata /workspace/prs/sim/out/v2m_eddy_rclamp_X5000_Ron2_q1_rb12.dat v(n1) v(n2) v(n3) v(x) v(P) v(bk) v(lam_iso) v(lam_SR1) v(lam_SR2) v(lam_SR3) i(L_iso_air) i(V_iso_cw) v(chg) v(a0) i(L_leak) v(iso_m) i(V_mit)
quit
.endc
.end
